simultaneous_second_002
Vminute m 0 4.095
Rminute m 0 56440
Vsecond s 0 4.095
Rsecond s 0 56440

.control
set wr_singlescale
set wr_vecnames
op
wrdata results/simultaneous_second_002.dat i(Vminute) i(Vsecond)
quit
.endc
.end
