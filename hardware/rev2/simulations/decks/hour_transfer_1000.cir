hour_transfer_1000
.include models/OPAx197.LIB
Vboost vp 0 15
Vcmd dac 0 PWL(0 .05 1m .05 11m 4.096)
Xd amp_in fb vp 0 drive OPAx197
Rprotect dac amp_in 4700
Rf out fb 22000
Rg fb 0 10000
Riso drive out 47
Cf drive fb 1n
Rmeter out 0 1000

.control
set wr_singlescale
set wr_vecnames
tran 10u 12m 0 10u
wrdata results/hour_transfer_1000.dat v(dac) v(out)
quit
.endc
.end
