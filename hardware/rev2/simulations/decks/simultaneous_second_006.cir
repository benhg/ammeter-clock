simultaneous_second_006
Vminute m 0 4.095
Rminute m 0 56000
Vsecond s 0 4.095
Rsecond s 0 56000

.control
set wr_singlescale
set wr_vecnames
op
wrdata results/simultaneous_second_006.dat i(Vminute) i(Vsecond)
quit
.endc
.end
