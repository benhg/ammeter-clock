ripple_usb
.include models/OPAx197.LIB
Vusb usb 0 SIN(5 .05 100)
Bdac dac 0 V=(.3+3.45*min(time/0.001,1)) + (V(usb)-5)*3.75*10^(-57/20)/5
Vboost vp 0 15
Xd amp_in fb vp 0 drive OPAx197
Rprotect dac amp_in 4700
Rf out fb 22000
Rg fb 0 10000
Riso drive out 47
Cf drive fb 1n
Rmeter out 0 100000

.control
set wr_singlescale
set wr_vecnames
tran 10u 50m 0 10u
wrdata results/ripple_usb.dat v(out) v(vp)
quit
.endc
.end
