simultaneous_second_001
Vminute m 0 4.095
Rminute m 0 55460
Vsecond s 0 4.095
Rsecond s 0 55460

.control
set wr_singlescale
set wr_vecnames
op
wrdata results/simultaneous_second_001.dat i(Vminute) i(Vsecond)
quit
.endc
.end
