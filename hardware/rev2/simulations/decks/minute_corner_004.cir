minute_corner_004
Vdac dac 0 4.095
VoutputSense dac series 0
Rseries series meter 55440
Rcoil meter 0 10000

.control
set wr_singlescale
set wr_vecnames
op
wrdata results/minute_corner_004.dat i(Vdac)
quit
.endc
.end
