simultaneous_second_007
Vminute m 0 4.095
Rminute m 0 56020
Vsecond s 0 4.095
Rsecond s 0 56020

.control
set wr_singlescale
set wr_vecnames
op
wrdata results/simultaneous_second_007.dat i(Vminute) i(Vsecond)
quit
.endc
.end
