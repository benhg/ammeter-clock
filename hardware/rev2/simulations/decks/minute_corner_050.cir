minute_corner_050
Vdac dac 0 4.095
VoutputSense dac series 0
Rseries series meter 56560
Rcoil meter 0 1000

.control
set wr_singlescale
set wr_vecnames
op
wrdata results/minute_corner_050.dat i(Vdac)
quit
.endc
.end
