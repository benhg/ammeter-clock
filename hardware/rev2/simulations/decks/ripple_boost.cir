ripple_boost
.include models/OPAx197.LIB
Vdac dac 0 PWL(0 .3 1m .3 1.001m 3.75)
Vboost vp 0 SIN(15 .05 100)
Xd amp_in fb vp 0 drive OPAx197
Rprotect dac amp_in 4700
Rf out fb 22000
Rg fb 0 10000
Riso drive out 47
Cf drive fb 1n
Rmeter out 0 100000

.control
set wr_singlescale
set wr_vecnames
tran 10u 50m 0 10u
wrdata results/ripple_boost.dat v(out) v(vp)
quit
.endc
.end
