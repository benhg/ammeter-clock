minute_corner_034
Vdac dac 0 4.095
VoutputSense dac series 0
Rseries series meter 56560
Rcoil meter 0 10000

.control
set wr_singlescale
set wr_vecnames
op
wrdata results/minute_corner_034.dat i(Vdac)
quit
.endc
.end
